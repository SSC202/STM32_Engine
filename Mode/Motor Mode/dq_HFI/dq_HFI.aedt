# Ansys Electronics Desktop project, version 2024.2
materials:
  vacuum: permittivity=1
  DW540_50: permeability{HUnit=A_per_meter BUnit=tesla curve (0, 0) (66, 0.4) (70, 0.45) (74, 0.5) (78, 0.55) (82, 0.6) (88, 0.65) (92, 0.7) (97, 0.75) (104, 0.8) (111, 0.85) (118, 0.9) (126, 0.95) (136, 1) (148, 1.05) (161, 1.1) (179, 1.15) (203, 1.2) (239, 1.25) (287, 1.3) (350, 1.35) (462, 1.4) (637, 1.45) (955, 1.5) (1513, 1.55) (2548, 1.6) (3822, 1.65) (5255, 1.7) (6847, 1.75) (10035, 1.8) (14006, 1.85) (19085, 1.9) (25048, 1.95) (32047, 2) (42605, 2.05) (56529, 2.1) (78025, 2.15) (103500, 2.2) (127390, 2.25) (156050, 2.3) (191080, 2.35)} core_loss_type="Electrical Steel" core_loss_kh=268 core_loss_kc=0.822 mass_density=7750
  DW465_50: permeability{HUnit=A_per_meter BUnit=tesla curve (0, 0) (64, 0.4) (68, 0.45) (72, 0.5) (75, 0.55) (77, 0.6) (79, 0.65) (80, 0.7) (84, 0.75) (88, 0.8) (96, 0.85) (104, 0.9) (112, 0.95) (121, 1) (134, 1.05) (143, 1.1) (167, 1.15) (189, 1.2) (223, 1.25) (263, 1.3) (318, 1.35) (430, 1.4) (669, 1.45) (995, 1.5) (1592, 1.55) (2548, 1.6) (3742, 1.65) (5096, 1.7) (6688, 1.75) (10098, 1.8) (15029, 1.85) (21045, 1.9) (28061, 1.95) (38191, 2) (51338, 2.05) (70038, 2.1) (102070, 2.15) (130740, 2.2) (161790, 2.25)} core_loss_type="Electrical Steel" core_loss_kh=190 core_loss_kc=0.822 mass_density=7700
  copper: permeability=0.999991 conductivity=58000000
  HC_NdFe42_2DSF1.000_X: permeability=1.03436 conductivity=555556 magnetic_coercivity{Magnitude=-957834A_per_meter DirComp1=1 DirComp2=0 DirComp3=0}

design q_HFI (Maxwell 2D, Transient, XY geometry, model units mm)
options: ComputeTransientInductance ModelDepth=52mm
variables:
  fractions = 4
  conds = 42
geometry:
  Stator [DW465_50] = imported_body(D:/Users/ws199/AppData/Local/Temp/383C1061217020125992..x_t)
  _1 = imported_body(D:/Users/ws199/AppData/Local/Temp/383C1061217020125992..x_t)
  _1_1 = _1.copy()
  Stator.subtract(_1_1)
  _1.delete()
  Stator.rotate(axis=Z, angle=(-360/36/2) deg)
  Stator.rotate(axis=Z, angle=180deg)
  Stator.split(plane=YZ, keep=PositiveOnly)
  Stator.split(plane=ZX, keep=PositiveOnly)
  Coil_0 [copper] = user_primitive(RMxprt/LapCoil, DiaGap=86mm, DiaYoke=130mm, Length=0mm, Skew=0deg, Slots=36, SlotType=2, Hs0=0.65mm, Hs1=0.5mm, Hs2=12mm, Bs0=2.1mm, Bs1=4.10925mm, Bs2=6.20898mm, Rs=3.10449mm, FilletType=0, Layers=2, CoilPitch=5, EndExt=14.709713mm, SpanExt=0mm, BendAngle=0deg, SegAngle=10deg, LenRegion=0mm, InfoCoil=2)
  Coil_1..Coil_8 [copper], Coil_9..Coil_35 = Coil_0.duplicate_around_axis(axis=Z, angle=10deg, total=36)
  Coil_0.unite(Coil_9, Coil_18, Coil_27)
  Tool = user_primitive(RMxprt/Band, DiaGap=85.35mm, DiaYoke=130mm, Length=0mm, SegAngle=0deg, Fractions=fractions, HalfAxial=0, InfoCore=1)
  Tool_5 = Tool.copy()
  Coil_0.subtract(Tool_5)
  Coil_1.unite(Coil_10, Coil_19, Coil_28)
  Tool_6 = Tool.copy()
  Coil_1.subtract(Tool_6)
  Coil_2.unite(Coil_11, Coil_20, Coil_29)
  Tool_7 = Tool.copy()
  Coil_2.subtract(Tool_7)
  Coil_3.unite(Coil_12, Coil_21, Coil_30)
  Tool_8 = Tool.copy()
  Coil_3.subtract(Tool_8)
  Coil_4.unite(Coil_13, Coil_22, Coil_31)
  Tool_9 = Tool.copy()
  Coil_4.subtract(Tool_9)
  Coil_5.unite(Coil_14, Coil_23, Coil_32)
  Tool_10 = Tool.copy()
  Coil_5.subtract(Tool_10)
  Coil_6.unite(Coil_15, Coil_24, Coil_33)
  Tool_11 = Tool.copy()
  Coil_6.subtract(Tool_11)
  Coil_7.unite(Coil_16, Coil_25, Coil_34)
  Tool_12 = Tool.copy()
  Coil_7.subtract(Tool_12)
  Coil_8.unite(Coil_17, Coil_26, Coil_35)
  Tool_13 = Tool.copy()
  Coil_8.subtract(Tool_13)
  CoilRe_0 [copper] = user_primitive(RMxprt/LapCoil, DiaGap=86mm, DiaYoke=130mm, Length=0mm, Skew=0deg, Slots=36, SlotType=2, Hs0=0.65mm, Hs1=0.5mm, Hs2=12mm, Bs0=2.1mm, Bs1=4.10925mm, Bs2=6.20898mm, Rs=3.10449mm, FilletType=0, Layers=2, CoilPitch=5, EndExt=14.709713mm, SpanExt=0mm, BendAngle=0deg, SegAngle=10deg, LenRegion=0mm, InfoCoil=3)
  CoilRe_0.rotate(axis=Z, angle=-50deg)
  CoilRe_1..CoilRe_8 [copper], CoilRe_9..CoilRe_35 = CoilRe_0.duplicate_around_axis(axis=Z, angle=10deg, total=36)
  CoilRe_0.unite(CoilRe_9, CoilRe_18, CoilRe_27)
  Tool_14 = Tool.copy()
  CoilRe_0.subtract(Tool_14)
  CoilRe_1.unite(CoilRe_10, CoilRe_19, CoilRe_28)
  Tool_15 = Tool.copy()
  CoilRe_1.subtract(Tool_15)
  CoilRe_2.unite(CoilRe_11, CoilRe_20, CoilRe_29)
  Tool_16 = Tool.copy()
  CoilRe_2.subtract(Tool_16)
  CoilRe_3.unite(CoilRe_12, CoilRe_21, CoilRe_30)
  Tool_17 = Tool.copy()
  CoilRe_3.subtract(Tool_17)
  CoilRe_4.unite(CoilRe_13, CoilRe_22, CoilRe_31)
  Tool_18 = Tool.copy()
  CoilRe_4.subtract(Tool_18)
  CoilRe_5.unite(CoilRe_14, CoilRe_23, CoilRe_32)
  Tool_19 = Tool.copy()
  CoilRe_5.subtract(Tool_19)
  CoilRe_6.unite(CoilRe_15, CoilRe_24, CoilRe_33)
  Tool_20 = Tool.copy()
  CoilRe_6.subtract(Tool_20)
  CoilRe_7.unite(CoilRe_16, CoilRe_25, CoilRe_34)
  Tool_21 = Tool.copy()
  CoilRe_7.subtract(Tool_21)
  CoilRe_8.unite(CoilRe_17, CoilRe_26, CoilRe_35)
  Tool_22 = Tool.copy()
  CoilRe_8.subtract(Tool_22)
  Tool.delete()
  coordinate_system relativeCS_06 = origin=(0, 0, 0) x=(0.92388, 0.382683, 0) y=(-0.382683, 0.92388, 0)
  Mag_N [HC_NdFe42_2DSF1.000_X, oriented by relativeCS_06] = user_primitive(RMxprt/IPMCore, DiaGap=84.7mm, DiaYoke=30mm, Length=0mm, Poles=8, PoleType=2, D1=82.14mm, O1=0mm, O2=19.750045mm, B1=4mm, Rib=2.2mm, HRib=3.8977241mm, DminMag=0mm, ThickMag=4mm, WidthMag=24mm, LenRegion=0mm, InfoCore=3)
  Mag_N.rotate(axis=Z, angle=22.5deg)
  Mag_S [HC_NdFe42_2DSF1.000_X, oriented by relativeCS_7], Mag_2..Mag_7 = Mag_N.duplicate_around_axis(axis=Z, angle=45deg, total=8)
  Mag_N.unite(Mag_2, Mag_4, Mag_6)
  Tool1 = user_primitive(RMxprt/Band, DiaGap=85.35mm, DiaYoke=130mm, Length=0mm, SegAngle=0deg, Fractions=fractions, HalfAxial=0, InfoCore=1)
  Tool_24 = Tool1.copy()
  Mag_N.subtract(Tool_24)
  coordinate_system relativeCS_7 = origin=(0, 0, 0) x=(-0.382683, -0.92388, 0) y=(0.92388, -0.382683, 0)
  Mag_S.unite(Mag_3, Mag_5, Mag_7)
  Mag_S.subtract(Tool1)
  Band [vacuum] = user_primitive(RMxprt/Band, DiaGap=85.35mm, DiaYoke=30mm, Length=0mm, SegAngle=0deg, Fractions=1, HalfAxial=0, InfoCore=0)
  Tool2 = user_primitive(RMxprt/Band, DiaGap=85.35mm, DiaYoke=130mm, Length=0mm, SegAngle=0deg, Fractions=fractions, HalfAxial=0, InfoCore=1)
  Tool_1 = Tool2.copy()
  Band.subtract(Tool_1)
  OuterRegion [vacuum] = user_primitive(RMxprt/Band, DiaGap=85.35mm, DiaYoke=130mm, Length=0mm, SegAngle=0deg, Fractions=fractions, HalfAxial=0, InfoCore=100)
  InnerRegion [vacuum] = user_primitive(RMxprt/IPMCore, DiaGap=84.7mm, DiaYoke=30mm, Length=0mm, Poles=8, PoleType=2, D1=82.7mm, O1=0mm, O2=20.014228mm, B1=4mm, Rib=2.2mm, HRib=3.8918739mm, DminMag=0mm, ThickMag=4mm, WidthMag=24mm, LenRegion=0mm, InfoCore=100)
  Tool_2 = Tool2.copy()
  InnerRegion.subtract(Tool_2)
  Tool2.delete()
  Rotor [DW465_50] = imported_body()
motion:
  MotionSetup1: Band Move_Type=Rotate Coordinate_System=Global Axis=Z Is_Positive=true InitPos=35deg Angular_Velocity=0rpm Objects=Band
  Moving1: Moving Objects=[Rotor, Mag_N, Mag_S, InnerRegion]
boundaries and excitations:
  VectorPotential1: Vector Potential Edges=OuterRegion.edge(at (45.9619, 45.9619, 0)) Value=0
  Independent1: Independent Edges=OuterRegion.edge(at (32.5, 0, 0))
  Dependent1: Dependent Edges=OuterRegion.edge(at (0, 32.5, 0)) ReverseU Independent=Independent1 SameAsMaster=true
  PhA_0: Coil Objects=Coil_0 Conductor_number=conds Winding=PhaseA PolarityType=Positive
  PhARe_0: Coil Objects=CoilRe_5 Conductor_number=conds Winding=PhaseA PolarityType=Negative
  PhA_1: Coil Objects=Coil_1 Conductor_number=conds Winding=PhaseA PolarityType=Positive
  PhARe_1: Coil Objects=CoilRe_6 Conductor_number=conds Winding=PhaseA PolarityType=Negative
  PhCRe_2: Coil Objects=Coil_2 Conductor_number=conds Winding=PhaseC PolarityType=Negative
  PhC_2: Coil Objects=CoilRe_7 Conductor_number=conds Winding=PhaseC PolarityType=Positive
  PhB_3: Coil Objects=Coil_3 Conductor_number=conds Winding=PhaseB PolarityType=Positive
  PhBRe_3: Coil Objects=CoilRe_8 Conductor_number=conds Winding=PhaseB PolarityType=Negative
  PhB_4: Coil Objects=Coil_4 Conductor_number=conds Winding=PhaseB PolarityType=Positive
  PhARe_5: Coil Objects=Coil_5 Conductor_number=conds Winding=PhaseA PolarityType=Negative
  PhC_6: Coil Objects=Coil_6 Conductor_number=conds Winding=PhaseC PolarityType=Positive
  PhC_7: Coil Objects=Coil_7 Conductor_number=conds Winding=PhaseC PolarityType=Positive
  PhBRe_8: Coil Objects=Coil_8 Conductor_number=conds Winding=PhaseB PolarityType=Negative
  PhBRe_31: Coil Objects=CoilRe_0 Conductor_number=conds Winding=PhaseB PolarityType=Negative
  PhA_32: Coil Objects=CoilRe_1 Conductor_number=conds Winding=PhaseA PolarityType=Positive
  PhCRe_33: Coil Objects=CoilRe_2 Conductor_number=conds Winding=PhaseC PolarityType=Negative
  PhCRe_34: Coil Objects=CoilRe_3 Conductor_number=conds Winding=PhaseC PolarityType=Negative
  PhB_35: Coil Objects=CoilRe_4 Conductor_number=conds Winding=PhaseB PolarityType=Positive
  Current_1: Current Objects=Mag_S Current=0mA IsSolid=true IsPositive=true
  Current_2: Current Objects=Mag_N Current=0mA IsSolid=true IsPositive=true
  PhaseA: Winding Group Type=Current IsSolid=false Current=0.2*cos(2500*2*pi*time) ParallelBranchesNum=1
  PhaseB: Winding Group Type=Current IsSolid=false Current=0A ParallelBranchesNum=1
  PhaseC: Winding Group Type=Current IsSolid=false Current=0A ParallelBranchesNum=1
  core loss on: Stator, Rotor
mesh:
  SurfApprox_Mag: SurfApproxBased Objects=[Mag_N, Mag_S] CurvedSurfaceApproxChoice=ManualSettings SurfDev=0.04235mm NormalDev=15deg
  SurfApprox_Main: SurfApproxBased Objects=[Band, OuterRegion, InnerRegion] CurvedSurfaceApproxChoice=ManualSettings SurfDev=0.065mm NormalDev=15deg
  CylindricalGap1: CylindricalGap Objects=Band Objects=Band
setups:
  Setup1: Transient NonlinearSolverResidual=0.0001 StopTime=1ms TimeStep="(1/300) ms" SaveFieldsType="Every N Steps" N_Steps=1 Steps_From=0s Steps_To=10ms NumberSolveSteps=1 RangeStart=0s RangeEnd=0.1s InitialTimeStep=0.002s MinTimeStep=0.001s MaxTimeStep=0.003s TimeStepErrTolerance=0.0001
field plots:
  Loss_Density: Mag_Loss over Mag_S, Mag_N on Setup1 : Transient at Time=1ms Time0=0s
  Loss_Density1: Core_Loss over Stator, Rotor on Setup1 : Transient at Time=1ms Time0=0s
reports:
  Loss Plot 1: CoreLoss, SolidLoss vs Time on Setup1 : Transient

design d_HFI (Maxwell 2D, Transient, XY geometry, model units mm)
options: ComputeTransientInductance ModelDepth=52mm
variables:
  fractions = 4
  conds = 42
geometry:
  Stator [DW465_50] = imported_body(D:/Users/ws199/AppData/Local/Temp/383C1061217020125992..x_t)
  _1 = imported_body(D:/Users/ws199/AppData/Local/Temp/383C1061217020125992..x_t)
  _1_1 = _1.copy()
  Stator.subtract(_1_1)
  _1.delete()
  Stator.rotate(axis=Z, angle=(-360/36/2) deg)
  Stator.rotate(axis=Z, angle=180deg)
  Stator.split(plane=YZ, keep=PositiveOnly)
  Stator.split(plane=ZX, keep=PositiveOnly)
  Rotor [DW465_50] = imported_body()
  Coil_0 [copper] = user_primitive(RMxprt/LapCoil, DiaGap=86mm, DiaYoke=130mm, Length=0mm, Skew=0deg, Slots=36, SlotType=2, Hs0=0.65mm, Hs1=0.5mm, Hs2=12mm, Bs0=2.1mm, Bs1=4.10925mm, Bs2=6.20898mm, Rs=3.10449mm, FilletType=0, Layers=2, CoilPitch=5, EndExt=14.709713mm, SpanExt=0mm, BendAngle=0deg, SegAngle=10deg, LenRegion=0mm, InfoCoil=2)
  Coil_1..Coil_8 [copper], Coil_9..Coil_35 = Coil_0.duplicate_around_axis(axis=Z, angle=10deg, total=36)
  Coil_0.unite(Coil_9, Coil_18, Coil_27)
  Tool = user_primitive(RMxprt/Band, DiaGap=85.35mm, DiaYoke=130mm, Length=0mm, SegAngle=0deg, Fractions=fractions, HalfAxial=0, InfoCore=1)
  Tool_5 = Tool.copy()
  Coil_0.subtract(Tool_5)
  Coil_1.unite(Coil_10, Coil_19, Coil_28)
  Tool_6 = Tool.copy()
  Coil_1.subtract(Tool_6)
  Coil_2.unite(Coil_11, Coil_20, Coil_29)
  Tool_7 = Tool.copy()
  Coil_2.subtract(Tool_7)
  Coil_3.unite(Coil_12, Coil_21, Coil_30)
  Tool_8 = Tool.copy()
  Coil_3.subtract(Tool_8)
  Coil_4.unite(Coil_13, Coil_22, Coil_31)
  Tool_9 = Tool.copy()
  Coil_4.subtract(Tool_9)
  Coil_5.unite(Coil_14, Coil_23, Coil_32)
  Tool_10 = Tool.copy()
  Coil_5.subtract(Tool_10)
  Coil_6.unite(Coil_15, Coil_24, Coil_33)
  Tool_11 = Tool.copy()
  Coil_6.subtract(Tool_11)
  Coil_7.unite(Coil_16, Coil_25, Coil_34)
  Tool_12 = Tool.copy()
  Coil_7.subtract(Tool_12)
  Coil_8.unite(Coil_17, Coil_26, Coil_35)
  Tool_13 = Tool.copy()
  Coil_8.subtract(Tool_13)
  CoilRe_0 [copper] = user_primitive(RMxprt/LapCoil, DiaGap=86mm, DiaYoke=130mm, Length=0mm, Skew=0deg, Slots=36, SlotType=2, Hs0=0.65mm, Hs1=0.5mm, Hs2=12mm, Bs0=2.1mm, Bs1=4.10925mm, Bs2=6.20898mm, Rs=3.10449mm, FilletType=0, Layers=2, CoilPitch=5, EndExt=14.709713mm, SpanExt=0mm, BendAngle=0deg, SegAngle=10deg, LenRegion=0mm, InfoCoil=3)
  CoilRe_0.rotate(axis=Z, angle=-50deg)
  CoilRe_1..CoilRe_8 [copper], CoilRe_9..CoilRe_35 = CoilRe_0.duplicate_around_axis(axis=Z, angle=10deg, total=36)
  CoilRe_0.unite(CoilRe_9, CoilRe_18, CoilRe_27)
  Tool_14 = Tool.copy()
  CoilRe_0.subtract(Tool_14)
  CoilRe_1.unite(CoilRe_10, CoilRe_19, CoilRe_28)
  Tool_15 = Tool.copy()
  CoilRe_1.subtract(Tool_15)
  CoilRe_2.unite(CoilRe_11, CoilRe_20, CoilRe_29)
  Tool_16 = Tool.copy()
  CoilRe_2.subtract(Tool_16)
  CoilRe_3.unite(CoilRe_12, CoilRe_21, CoilRe_30)
  Tool_17 = Tool.copy()
  CoilRe_3.subtract(Tool_17)
  CoilRe_4.unite(CoilRe_13, CoilRe_22, CoilRe_31)
  Tool_18 = Tool.copy()
  CoilRe_4.subtract(Tool_18)
  CoilRe_5.unite(CoilRe_14, CoilRe_23, CoilRe_32)
  Tool_19 = Tool.copy()
  CoilRe_5.subtract(Tool_19)
  CoilRe_6.unite(CoilRe_15, CoilRe_24, CoilRe_33)
  Tool_20 = Tool.copy()
  CoilRe_6.subtract(Tool_20)
  CoilRe_7.unite(CoilRe_16, CoilRe_25, CoilRe_34)
  Tool_21 = Tool.copy()
  CoilRe_7.subtract(Tool_21)
  CoilRe_8.unite(CoilRe_17, CoilRe_26, CoilRe_35)
  Tool_22 = Tool.copy()
  CoilRe_8.subtract(Tool_22)
  Tool.delete()
  coordinate_system relativeCS_06 = origin=(0, 0, 0) x=(0.92388, 0.382683, 0) y=(-0.382683, 0.92388, 0)
  Mag_N [HC_NdFe42_2DSF1.000_X, oriented by relativeCS_06] = user_primitive(RMxprt/IPMCore, DiaGap=84.7mm, DiaYoke=30mm, Length=0mm, Poles=8, PoleType=2, D1=82.14mm, O1=0mm, O2=19.750045mm, B1=4mm, Rib=2.2mm, HRib=3.8977241mm, DminMag=0mm, ThickMag=4mm, WidthMag=24mm, LenRegion=0mm, InfoCore=3)
  Mag_N.rotate(axis=Z, angle=22.5deg)
  Mag_S [HC_NdFe42_2DSF1.000_X, oriented by relativeCS_7], Mag_2..Mag_7 = Mag_N.duplicate_around_axis(axis=Z, angle=45deg, total=8)
  Mag_N.unite(Mag_2, Mag_4, Mag_6)
  Tool1 = user_primitive(RMxprt/Band, DiaGap=85.35mm, DiaYoke=130mm, Length=0mm, SegAngle=0deg, Fractions=fractions, HalfAxial=0, InfoCore=1)
  Tool_24 = Tool1.copy()
  Mag_N.subtract(Tool_24)
  coordinate_system relativeCS_7 = origin=(0, 0, 0) x=(-0.382683, -0.92388, 0) y=(0.92388, -0.382683, 0)
  Mag_S.unite(Mag_3, Mag_5, Mag_7)
  Mag_S.subtract(Tool1)
  Band [vacuum] = user_primitive(RMxprt/Band, DiaGap=85.35mm, DiaYoke=30mm, Length=0mm, SegAngle=0deg, Fractions=1, HalfAxial=0, InfoCore=0)
  Tool2 = user_primitive(RMxprt/Band, DiaGap=85.35mm, DiaYoke=130mm, Length=0mm, SegAngle=0deg, Fractions=fractions, HalfAxial=0, InfoCore=1)
  Tool_1 = Tool2.copy()
  Band.subtract(Tool_1)
  OuterRegion [vacuum] = user_primitive(RMxprt/Band, DiaGap=85.35mm, DiaYoke=130mm, Length=0mm, SegAngle=0deg, Fractions=fractions, HalfAxial=0, InfoCore=100)
  InnerRegion [vacuum] = user_primitive(RMxprt/IPMCore, DiaGap=84.7mm, DiaYoke=30mm, Length=0mm, Poles=8, PoleType=2, D1=82.7mm, O1=0mm, O2=20.014228mm, B1=4mm, Rib=2.2mm, HRib=3.8918739mm, DminMag=0mm, ThickMag=4mm, WidthMag=24mm, LenRegion=0mm, InfoCore=100)
  Tool_2 = Tool2.copy()
  InnerRegion.subtract(Tool_2)
  Tool2.delete()
motion:
  MotionSetup1: Band Move_Type=Rotate Coordinate_System=Global Axis=Z Is_Positive=true InitPos="(35-22.5) deg" Angular_Velocity=0rpm Objects=Band
  Moving1: Moving Objects=[Rotor, Mag_N, Mag_S, InnerRegion]
boundaries and excitations:
  VectorPotential1: Vector Potential Edges=OuterRegion.edge(at (45.9619, 45.9619, 0)) Value=0
  Independent1: Independent Edges=OuterRegion.edge(at (32.5, 0, 0))
  Dependent1: Dependent Edges=OuterRegion.edge(at (0, 32.5, 0)) ReverseU Independent=Independent1 SameAsMaster=true
  PhA_0: Coil Objects=Coil_0 Conductor_number=conds Winding=PhaseA PolarityType=Positive
  PhARe_0: Coil Objects=CoilRe_5 Conductor_number=conds Winding=PhaseA PolarityType=Negative
  PhA_1: Coil Objects=Coil_1 Conductor_number=conds Winding=PhaseA PolarityType=Positive
  PhARe_1: Coil Objects=CoilRe_6 Conductor_number=conds Winding=PhaseA PolarityType=Negative
  PhCRe_2: Coil Objects=Coil_2 Conductor_number=conds Winding=PhaseC PolarityType=Negative
  PhC_2: Coil Objects=CoilRe_7 Conductor_number=conds Winding=PhaseC PolarityType=Positive
  PhB_3: Coil Objects=Coil_3 Conductor_number=conds Winding=PhaseB PolarityType=Positive
  PhBRe_3: Coil Objects=CoilRe_8 Conductor_number=conds Winding=PhaseB PolarityType=Negative
  PhB_4: Coil Objects=Coil_4 Conductor_number=conds Winding=PhaseB PolarityType=Positive
  PhARe_5: Coil Objects=Coil_5 Conductor_number=conds Winding=PhaseA PolarityType=Negative
  PhC_6: Coil Objects=Coil_6 Conductor_number=conds Winding=PhaseC PolarityType=Positive
  PhC_7: Coil Objects=Coil_7 Conductor_number=conds Winding=PhaseC PolarityType=Positive
  PhBRe_8: Coil Objects=Coil_8 Conductor_number=conds Winding=PhaseB PolarityType=Negative
  PhBRe_31: Coil Objects=CoilRe_0 Conductor_number=conds Winding=PhaseB PolarityType=Negative
  PhA_32: Coil Objects=CoilRe_1 Conductor_number=conds Winding=PhaseA PolarityType=Positive
  PhCRe_33: Coil Objects=CoilRe_2 Conductor_number=conds Winding=PhaseC PolarityType=Negative
  PhCRe_34: Coil Objects=CoilRe_3 Conductor_number=conds Winding=PhaseC PolarityType=Negative
  PhB_35: Coil Objects=CoilRe_4 Conductor_number=conds Winding=PhaseB PolarityType=Positive
  Current_1: Current Objects=Mag_S Current=0mA IsSolid=true IsPositive=true
  Current_2: Current Objects=Mag_N Current=0mA IsSolid=true IsPositive=true
  PhaseA: Winding Group Type=Current IsSolid=false Current=0.2*cos(2500*2*pi*time) ParallelBranchesNum=1
  PhaseB: Winding Group Type=Current IsSolid=false Current=0A ParallelBranchesNum=1
  PhaseC: Winding Group Type=Current IsSolid=false Current=0A ParallelBranchesNum=1
  core loss on: Stator, Rotor
mesh:
  SurfApprox_Mag: SurfApproxBased Objects=[Mag_N, Mag_S] CurvedSurfaceApproxChoice=ManualSettings SurfDev=0.04235mm NormalDev=15deg
  SurfApprox_Main: SurfApproxBased Objects=[Band, OuterRegion, InnerRegion] CurvedSurfaceApproxChoice=ManualSettings SurfDev=0.065mm NormalDev=15deg
  CylindricalGap1: CylindricalGap Objects=Band Objects=Band
setups:
  Setup1: Transient NonlinearSolverResidual=0.0001 StopTime=1ms TimeStep="(1/300) ms" SaveFieldsType="Every N Steps" N_Steps=1 Steps_From=0s Steps_To=1ms NumberSolveSteps=1 RangeStart=0s RangeEnd=0.1s InitialTimeStep=0.002s MinTimeStep=0.001s MaxTimeStep=0.003s TimeStepErrTolerance=0.0001
field plots:
  Flux_Lines1: A over Stator, Rotor, Coil_0..Coil_8, CoilRe_0..CoilRe_8, Mag_N, Mag_S, Band, OuterRegion, InnerRegion on Setup1 : Transient at Time=0.001s
  Loss_Density: Mag_Loss over Mag_N, Mag_S on Setup1 : Transient at Time=1ms Time0=0s
  Loss_Density1: Core_Loss over Rotor, Stator on Setup1 : Transient at Time=1ms Time0=0s
reports:
  Loss: CoreLoss, SolidLoss vs Time on Setup1 : Transient
