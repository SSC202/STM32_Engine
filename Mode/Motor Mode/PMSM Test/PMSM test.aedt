# Ansys Electronics Desktop project, version 2024.2
materials:
  vacuum: permittivity=1
  DW310_35: permeability{HUnit=A_per_meter BUnit=tesla curve (0, 0) (58, 0.4) (60, 0.45) (62, 0.5) (64, 0.55) (68, 0.6) (72, 0.65) (75, 0.7) (78, 0.75) (84, 0.8) (92, 0.85) (100, 0.9) (107, 0.95) (116, 1) (127, 1.05) (143, 1.1) (167, 1.15) (197, 1.2) (239, 1.25) (303, 1.3) (422, 1.35) (597, 1.4) (955, 1.45) (1592, 1.5) (2389, 1.55) (3462, 1.6) (5096, 1.65) (6529, 1.7) (8262, 1.75) (10988, 1.8) (14730, 1.85) (18313, 1.9) (23090, 1.95) (30892, 2) (47771, 2.05) (74045, 2.1)} core_loss_type="Electrical Steel" core_loss_kh=179 core_loss_kc=0.403 mass_density=7650
  DW315_50: permeability{HUnit=A_per_meter BUnit=tesla curve (0, 0) (49, 0.4) (52, 0.45) (55, 0.5) (57, 0.55) (61, 0.6) (64, 0.65) (68, 0.7) (73, 0.75) (79, 0.8) (84, 0.85) (95, 0.9) (103, 0.95) (115, 1) (124, 1.05) (142, 1.1) (163, 1.15) (193, 1.2) (235, 1.25) (299, 1.3) (390, 1.35) (518, 1.4) (796, 1.45) (1234, 1.5) (1990, 1.55) (3026, 1.6) (4299, 1.65) (6051, 1.7) (8962, 1.75) (11934, 1.8) (17950, 1.85) (24364, 1.9) (31052, 1.95) (42606, 2) (61530, 2.05) (86004, 2.1) (120570, 2.15)} core_loss_type="Electrical Steel" core_loss_kh=155 core_loss_kc=0.822 mass_density=7600
  NdFe35: permittivity=1 permeability=1.0997785 conductivity=625000 magnetic_coercivity{Magnitude=-890000A_per_meter DirComp1=1 DirComp2=0 DirComp3=0} lande_g_factor=2
  NdFe35 - N: CoordinateSystemType=Cylindrical permittivity=1 permeability=1.0997785 conductivity=625000 magnetic_coercivity{Magnitude=-890000A_per_meter DirComp1=1 DirComp2=0 DirComp3=0} lande_g_factor=2
  NdFe35 - S: CoordinateSystemType=Cylindrical permittivity=1 permeability=1.0997785 conductivity=625000 magnetic_coercivity{Magnitude=-890000A_per_meter DirComp1=-1 DirComp2=0 DirComp3=0} lande_g_factor=2
  copper: permeability=0.999991 conductivity=58000000

design Load (Maxwell 2D, Transient, XY geometry, model units mm)
options: ModelDepth=100mm
geometry:
  Stator [DW315_50] = user_primitive(RMxprt/SlotCore.dll, DiaGap=100mm, DiaYoke=150mm, Length=0mm, Skew=0deg, Slots=12, SlotType=4, Hs0=1mm, Hs01=0mm, Hs1=1mm, Hs2=12mm, Bs0=2.5mm, Bs1=12mm, Bs2=0mm, Rs=1mm, FilletType=0, HalfSlot=0, SegAngle=15deg, LenRegion=200mm, InfoCore=0)
  PM [NdFe35 - N] = user_primitive(RMxprt/PMCore.dll, DiaGap=98mm, DiaYoke=40mm, Length=0mm, Poles=8, PoleType=1, Embrace=0.85, ThickMag=8mm, WidthMag=45mm, Offset=0mm, Bridge=2mm, Rib=3mm, LenRegion=200mm, InfoCore=1)
  Rotor [DW315_50] = user_primitive(RMxprt/PMCore.dll, DiaGap=98mm, DiaYoke=40mm, Length=0mm, Poles=8, PoleType=1, Embrace=0.85, ThickMag=8mm, WidthMag=45mm, Offset=0mm, Bridge=2mm, Rib=3mm, LenRegion=200mm, InfoCore=0)
  PM_Separate7 [NdFe35 - S] = PM.separate_bodies()
  Stator.rotate(axis=Z, angle=(360/24) deg)
  Rectangle1 [copper] = rectangle(corner=(0mm, 52mm, 0mm), x_size=12mm, y_size=16mm)
  Stator_1 = Stator.copy()
  Rectangle1.subtract(Stator_1)
  Rectangle1_1 [copper] = Rectangle1.duplicate_mirror(point=(0mm, 64.984373mm, 0mm), normal=(1mm, 0mm, 0mm))
  Rectangle1_1_10, Rectangle1_1_11 [copper] = Rectangle1_1.duplicate_around_axis(axis=Z, angle=(360/12) deg, total=12)  # copies kept: 10, 11
  Rectangle1_11, Rectangle1_12 [copper] = Rectangle1.duplicate_around_axis(axis=Z, angle=(360/12) deg, total=12)  # copies kept: 10, 11
  inner_region [vacuum] = circle(normal=Z, centre=(0mm, 0mm, 0mm), radius=49mm)
  outer_region [vacuum] = circle(normal=Z, centre=(0mm, 0mm, 0mm), radius=75mm)
  band [vacuum] = circle(normal=Z, centre=(0mm, 0mm, 0mm), radius=49.5mm)
  [Rectangle1, Rectangle1_1, Rectangle1_1_10, Rectangle1_1_11, Rectangle1_11, Rectangle1_12, Stator].rotate(axis=Z, angle=0deg)
  [Rectangle1, Rectangle1_1, Rectangle1_1_10, Rectangle1_1_11, Rectangle1_11, Rectangle1_12, Stator].rotate(axis=Z, angle=(-360/24) deg)
  [Stator, PM, Rotor, PM_Separate7, Rectangle1, Rectangle1_1, Rectangle1_1_10, Rectangle1_1_11, Rectangle1_11, Rectangle1_12, inner_region, outer_region, band].split(plane=YZ, keep=PositiveOnly)
  [Stator, PM, Rotor, PM_Separate7, Rectangle1, Rectangle1_1, Rectangle1_1_10, Rectangle1_1_11, Rectangle1_11, Rectangle1_12, inner_region, outer_region, band].split(plane=ZX, keep=PositiveOnly)
  Polyline1 [non-model] = polyline(z=0mm, xy in mm: (49.5, 0) (35.001786, 35.001786) (3.0310008e-15, 49.5), AngularArc from point 0 over 3 centre=(0mm, 0mm, 0mm) angle=90deg plane=XY)
motion:
  MotionSetup1: Band Move_Type=Rotate Coordinate_System=Global Axis=Z Is_Positive=true InitPos=0deg Angular_Velocity=3000rpm Objects=band
  Moving1: Moving Objects=[PM, Rotor, PM_Separate7, inner_region]
boundaries and excitations:
  Independent1: Independent Edges=outer_region.edge(at (37.5, 0, 0)) ReverseV
  Dependent1: Dependent Edges=outer_region.edge(at (0, 37.5, 0)) Independent=Independent1 SameAsMaster=true
  VectorPotential1: Vector Potential Edges=outer_region.edge(at (53.033, 53.033, 0)) Value=0
  A+: Coil Objects=Rectangle1_1_10 Conductor_number=30 Winding=WindingA PolarityType=Positive
  A-: Coil Objects=Rectangle1_12 Conductor_number=30 Winding=WindingA PolarityType=Negative
  B+: Coil Objects=Rectangle1_1_11 Conductor_number=30 Winding=WindingB PolarityType=Positive
  B-: Coil Objects=Rectangle1 Conductor_number=30 Winding=WindingB PolarityType=Negative
  C+: Coil Objects=Rectangle1_1 Conductor_number=30 Winding=WindingC PolarityType=Positive
  C-: Coil Objects=Rectangle1_11 Conductor_number=30 Winding=WindingC PolarityType=Negative
  WindingA: Winding Group Type=Current IsSolid=false Current=10*sqrt(2)*sin(2*pi*3000/60*4*time) ParallelBranchesNum=1
  WindingB: Winding Group Type=Current IsSolid=false Current=10*sqrt(2)*sin(2*pi*3000/60*4*time-2*pi/3) ParallelBranchesNum=1
  WindingC: Winding Group Type=Current IsSolid=false Current=10*sqrt(2)*sin(2*pi*3000/60*4*time-4*pi/3) ParallelBranchesNum=1
  eddy effects on: PM, PM_Separate7
  core loss on: Stator, Rotor
mesh:
  CylindricalGap1: CylindricalGap Objects=band Objects=band
  Length1: LengthBased Objects=[Rectangle1, Rectangle1_1, Rectangle1_1_10, Rectangle1_1_11, Rectangle1_11, Rectangle1_12] MaxLength=3.0554203mm
  Length2: LengthBased Objects=[Rotor, Stator] MaxLength=15mm
  Length3: LengthBased Objects=PM MaxLength=6.0269333mm
  Length4: LengthBased Objects=PM_Separate7 MaxLength=6.0269333mm
  Length5: LengthBased Objects=[inner_region, outer_region] MaxLength=15mm
  Length6: LengthBased Objects=band MaxLength=2mm
setups:
  Setup1: Transient NonlinearSolverResidual=0.0001 StopTime="(60/3000/4*2) s" TimeStep="(60/3000/4*2/100) s" SaveFieldsType=Custom SweepRanges{0s to 0.01s step 0.0001s} NumberSolveSteps=1 RangeStart=0s RangeEnd=0.1s InitialTimeStep=0.002s MinTimeStep=0.001s MaxTimeStep=0.003s TimeStepErrTolerance=0.0001
field calculator expressions:
  Br = Fundamental_Quantity(22) | ScalarX | Scalar_Function(FuncValue='PHI') | UMathFunc | * | Fundamental_Quantity(22) | ScalarY | Scalar_Function(FuncValue='PHI') | UMathFunc | * | +
field plots:
  Mag_B1: B on Setup1 : Transient at Time=0.009s
  Flux_Lines1: A on Setup1 : Transient at Time=0.009s
